** sch_path: /foss/designs/low-power-12b-first-order-delta-sigma-adc/src/schematics/integrator_first_order/integrator.sch
.subckt integrator clk1 clk2 Vinp Voutp Voutn Vinn VSS gnd
*.ipin Vin+
*.ipin Vin-
*.opin Vout+
*.opin Vout-
XM1 net1 clk2 gnd VSS nfet_03v3 L=0.3u W=7.5u nf=1 ad='int((nf+1)/2) * W/nf * 0.18u' as='int((nf+2)/2) * W/nf * 0.18u' pd='2*int((nf+1)/2) * (W/nf + 0.18u)'
+ ps='2*int((nf+2)/2) * (W/nf + 0.18u)' nrd='0.18u / W' nrs='0.18u / W' sa=0 sb=0 sd=0
XM2 net2 clk1 gnd VSS nfet_03v3 L=0.3u W=7.5u nf=1 ad='int((nf+1)/2) * W/nf * 0.18u' as='int((nf+2)/2) * W/nf * 0.18u' pd='2*int((nf+1)/2) * (W/nf + 0.18u)'
+ ps='2*int((nf+2)/2) * (W/nf + 0.18u)' nrd='0.18u / W' nrs='0.18u / W' sa=0 sb=0 sd=0
XM3 Vinp clk1 net1 VSS nfet_03v3 L=0.3u W=7.5u nf=1 ad='int((nf+1)/2) * W/nf * 0.18u' as='int((nf+2)/2) * W/nf * 0.18u' pd='2*int((nf+1)/2) * (W/nf + 0.18u)'
+ ps='2*int((nf+2)/2) * (W/nf + 0.18u)' nrd='0.18u / W' nrs='0.18u / W' sa=0 sb=0 sd=0
XM4 net2 clk2 Voutp VSS nfet_03v3 L=0.3u W=7.5u nf=1 ad='int((nf+1)/2) * W/nf * 0.18u' as='int((nf+2)/2) * W/nf * 0.18u' pd='2*int((nf+1)/2) * (W/nf + 0.18u)'
+ ps='2*int((nf+2)/2) * (W/nf + 0.18u)' nrd='0.18u / W' nrs='0.18u / W' sa=0 sb=0 sd=0
XC1 net1 net2 cap_mim_2f0_m4m5_noshield c_width=43.15u c_length=43.15u
XC2 Vinp Voutp cap_mim_2f0_m4m5_noshield c_width=75.88u c_length=75.88u
XM5 net3 clk2 gnd VSS nfet_03v3 L=0.3u W=7.5u nf=1 ad='int((nf+1)/2) * W/nf * 0.18u' as='int((nf+2)/2) * W/nf * 0.18u' pd='2*int((nf+1)/2) * (W/nf + 0.18u)'
+ ps='2*int((nf+2)/2) * (W/nf + 0.18u)' nrd='0.18u / W' nrs='0.18u / W' sa=0 sb=0 sd=0
XM6 net4 clk1 gnd VSS nfet_03v3 L=0.3u W=7.5u nf=1 ad='int((nf+1)/2) * W/nf * 0.18u' as='int((nf+2)/2) * W/nf * 0.18u' pd='2*int((nf+1)/2) * (W/nf + 0.18u)'
+ ps='2*int((nf+2)/2) * (W/nf + 0.18u)' nrd='0.18u / W' nrs='0.18u / W' sa=0 sb=0 sd=0
XM7 Vinn clk1 net3 VSS nfet_03v3 L=0.3u W=7.5u nf=1 ad='int((nf+1)/2) * W/nf * 0.18u' as='int((nf+2)/2) * W/nf * 0.18u' pd='2*int((nf+1)/2) * (W/nf + 0.18u)'
+ ps='2*int((nf+2)/2) * (W/nf + 0.18u)' nrd='0.18u / W' nrs='0.18u / W' sa=0 sb=0 sd=0
XM8 net4 clk2 Voutn VSS nfet_03v3 L=0.3u W=7.5u nf=1 ad='int((nf+1)/2) * W/nf * 0.18u' as='int((nf+2)/2) * W/nf * 0.18u' pd='2*int((nf+1)/2) * (W/nf + 0.18u)'
+ ps='2*int((nf+2)/2) * (W/nf + 0.18u)' nrd='0.18u / W' nrs='0.18u / W' sa=0 sb=0 sd=0
XC3 net3 net4 cap_mim_2f0_m4m5_noshield c_width=43.15u c_length=43.15u
XC4 Vinn Voutn cap_mim_2f0_m4m5_noshield c_width=75.88u c_length=75.88u
*V1 VDD 0 3.3
*V2 VSS 0 0
*V5 Vin+ 0 PULSE(-1 1 0 50u 50u 0 100u)
*V6 Vin- 0 PULSE(-1 1 0 50u 50u 0 100u)
*V7 clk1 0 PULSE(0 3.3 0 1n 1n 0.5u 1u)
*V8 clk2 0 PULSE(0 3.3 0 1n 1n 0.5u 1u)
.ends
.end
